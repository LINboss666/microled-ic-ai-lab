;; sc1_s3c4_apply_copy.il -- GENERATED by scripts/sc1_s3c4_fix_labels.py; do not hand-edit.
;;
;; Rows come from the pairing table, and every object is found by DATABASE RELATIONSHIP,
;; not by coordinate guessing: the label to move is the child of this terminal's own pin
;; figure whose theLabel equals the terminal name; the stale stub to delete is the line on
;; device/drawing whose endpoints equal the recorded old ones. Pin rectangles, terminals,
;; directions, nets, the cell-name label and the "[@instanceName]" text are never touched.
;; NEW_SIMULATION_RUNS = 0.

s4Lib = "microled_scan_s3c"
s4Copies = nil
s4Jobs = list(
  list("sc1_scan_power_1ch_s3c" "s3c4_top_sym_copy")
)
s4Moves = list(
  list("sc1_scan_power_1ch_s3c" "blank" -0.5875 -0.125)
  list("sc1_scan_power_1ch_s3c" "clk" -1.0875 0.625)
  list("sc1_scan_power_1ch_s3c" "core_ok33" 0.3625 0.0)
  list("sc1_scan_power_1ch_s3c" "scan" 0.0875 0.0)
  list("sc1_scan_power_1ch_s3c" "vdd18" -0.6 0.43125)
  list("sc1_scan_power_1ch_s3c" "vdd33" 0.125 0.05625)
  list("sc1_scan_power_1ch_s3c" "vscan" -1.40625 0.19375)
  list("sc1_scan_power_1ch_s3c" "vss" -1.05625 -1.06875)
)
s4Stubs = list(
  list("sc1_scan_power_1ch_s3c" "add" -1.25000 0.37500 -1.37500 0.37500)
  list("sc1_scan_power_1ch_s3c" "add" -1.25000 0.12500 -1.37500 0.12500)
  list("sc1_scan_power_1ch_s3c" "del" 1.25000 0.37500 1.37500 0.37500)
  list("sc1_scan_power_1ch_s3c" "del" 1.25000 0.12500 1.37500 0.12500)
)

;; copy-first proof: the planned cells name the SOURCE view, s4Jobs then targets the
;; copies, so the delivered Symbol views are not opened for write in this run
s4Copies = list(
  list("sc1_scan_power_1ch_s3c" "s3c4_top_sym_copy")
)

procedure(s4Val(v) if(v v "NONE"))
procedure(s4Target(job) nth(1 job))

procedure(s4FindLabel(cv term)
  let((res p f ch) ;; the text object drawn for this terminal's own pin figure
    res = nil
    foreach(tm cv~>terminals
      when(equal(tm~>name term)
        foreach(p tm~>pins
          foreach(f p~>figs
            foreach(ch dbGet(f 'children)
              when(and(res == nil equal(s4Val(dbGet(ch 'theLabel)) term)
                       or(equal(ch~>objType "label") equal(ch~>objType "textDisplay")))
                res = ch
              )
            )
          )
        )
      )
    )
    res
  )
)

procedure(s4FindLine(cv a b)
  let((res pts) ;; exact endpoint match, either order; the SKILL side does no arithmetic
    res = nil
    foreach(s cv~>shapes
      when(and(res == nil equal(s~>objType "line")
               equal(s4Val(dbGet(s 'layerName)) "device")
               equal(s4Val(dbGet(s 'purpose)) "drawing"))
        pts = dbGet(s 'points)
        when(and(pts equal(pts list(a b))) res = s)
        when(and(pts res == nil equal(pts list(b a))) res = s)
      )
    )
    res
  )
)

printf("S4-BEGIN jobs=%L moves=%L stubs=%L\n" length(s4Jobs) length(s4Moves) length(s4Stubs))
when(s4Copies
  foreach(cp s4Copies
    src = car(errset(dbOpenCellViewByType(s4Lib nth(0 cp) "symbol" nil "r")))
    new = car(errset(dbCopyCellView(src s4Lib nth(1 cp) "symbol" "symbol")))
    printf("S4-COPY %L -> %L made=%L\n" nth(0 cp) nth(1 cp) s4Val(new != nil))
    errset(dbClose(src))
  )
)
foreach(job s4Jobs
  cell = s4Target(job)
  plan = nth(0 job)
  cv = car(errset(dbOpenCellViewByType(s4Lib cell "symbol" nil "a")))
  when(cv
    foreach(st s4Stubs
      when(and(equal(nth(0 st) plan) equal(nth(1 st) "del"))
        a = list(nth(2 st) nth(3 st))
        b = list(nth(4 st) nth(5 st))
        f = s4FindLine(cv a b)
        printf("S4-STUB-DEL %L pts=(%L %L %L %L) found=%L deleted=%L\n"
               cell nth(2 st) nth(3 st) nth(4 st) nth(5 st) s4Val(f != nil)
               s4Val(if(f car(errset(dbDeleteObject(f))) nil)))
      )
    )
    foreach(st s4Stubs
      when(and(equal(nth(0 st) plan) equal(nth(1 st) "add"))
        g = car(errset(dbCreateLine(cv list("device" "drawing")
                                    list(list(nth(2 st) nth(3 st)) list(nth(4 st) nth(5 st))))))
        printf("S4-STUB-ADD %L pts=(%L %L %L %L) made=%L bbox=%L\n"
               cell nth(2 st) nth(3 st) nth(4 st) nth(5 st) s4Val(g != nil)
               s4Val(dbGet(g 'bBox)))
      )
    )
    foreach(mv s4Moves
      when(equal(nth(0 mv) plan)
        lab = s4FindLabel(cv nth(1 mv))
        when(lab
          before = dbGet(lab 'xy)
          ok = car(errset(dbMoveFig(lab cv list(list(nth(2 mv) nth(3 mv)) "R0" 1.0))))
          printf("S4-MOVE %L %L from=%L delta=(%L %L) moved=%L text=%L now=%L\n"
                 cell nth(1 mv) s4Val(before) nth(2 mv) nth(3 mv) s4Val(ok)
                 s4Val(dbGet(lab 'theLabel)) s4Val(dbGet(lab 'xy)))
        )
        unless(lab printf("S4-SKIP %L %L no owned label found\n" cell nth(1 mv)))
      )
    )
    errset(dbSave(cv))
    printf("S4-SAVED %L\n" cell)
    errset(dbClose(cv))
    printf("S4-CLOSED %L\n" cell)
  )
  unless(cv printf("S4-OPENFAIL %L\n" cell))
)
printf("S4-DONE\n")
nil
