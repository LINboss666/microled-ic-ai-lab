printf("B3-BEGIN\n")
cv = dbOpenCellViewByType("microled_cells" "c2mos_dff_1bit" "schematic" "schematic" "r")
printf("B3-CV %L\n" cv)
foreach(spec list("cv~viewType" "cv~insts" "length(cv~insts)" "cv -> viewType" "cv->viewType" "getattr(cv \"viewType\")" "dbGetAttr(cv \"viewType\")" "cv~cellName")
  r = loadstring(spec)
  printf("B3-LS %s => %L\n" spec r)
)
printf("B3_DONE\n")
exit()
