printf("A2-BEGIN\n")
printf("A2-HAVE-dbGet %L\n" getd('dbGet))
printf("A2-HAVE-dbGetq %L\n" getd('dbGetq))
printf("A2-HAVE-dbGetObjPropValue %L\n" getd('dbGetObjPropValue))
printf("A2-HAVE-dbGetInstPropVal %L\n" getd('dbGetParam))
printf("A2-HAVE-dbGetParam %L\n" getd('dbGetParam))
cv = dbOpenCellViewByType("microled_cells" "c2mos_dff_1bit" "schematic" "schematic" "r")
foreach(a list("instances" "nets" "terms" "figs" "labels" "props" "name" "viewName" "viewType" "cell" "techLib" "topLevel" "bBoxes")
  errset(printf("A2-CV %L => %L\n" a dbGet(cv a)))
)
inst = car(dbGet(cv "instances"))
foreach(a list("name" "model" "cellName" "libName" "viewName" "master" "props" "params" "instTerms" "objType")
  errset(printf("A2-INST %L => %L\n" a dbGet(inst a)))
)
foreach(p errset(dbGet(inst "props"))
  errset(printf("A2-PROP %L %L %L\n" dbGet(p "name") dbGet(p "type") dbGet(p "value")))
)
foreach(it dbGet(inst "instTerms")
  errset(printf("A2-ITERM %L net=%L term=%L\n" it dbGet(it "net") dbGet(it "term")))
  errset(printf("A2-ITERM-NETNAME %L\n" dbGet(dbGet(it "net") "name")))
  errset(printf("A2-ITERM-TERMNAME %L\n" dbGet(dbGet(it "term") "name")))
)
net = car(dbGet(cv "nets"))
foreach(a list("name" "instTerms" "allInstTerms" "figTerms" "wires" "numInstTerms" "instTermCount" "connStatus" "isGlobal" "labels")
  errset(printf("A2-NET %L => %L\n" a dbGet(net a)))
)
dbClose(cv)
printf("A2_DONE\n")
exit()
