printf("BS-BEGIN\n")
cv = dbOpenCellViewByType("microled_cells" "c2mos_dff_1bit" "schematic" "schematic" "r")
printf("BS-CV %L\n" cv)
printf("BS-VIEWTYPE %L\n" cv~viewType)
printf("BS-INSTCOUNT %L\n" length(cv~insts))
e = errset(printf("BS-INNER %L\n" cv~viewType))
printf("BS-ERRSET %L\n" e)
printf("BS_DONE\n")
exit()
