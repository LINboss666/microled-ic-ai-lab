printf("AP-BEGIN\n")
cv = dbOpenCellViewByType("microled_cells" "c2mos_dff_1bit" "schematic" "schematic" "r")
printf("AP-CV %L\n" cv)
errset(printf("AP-CV-INSTANCES %L\n" length(cv->instances)))
errset(printf("AP-CV-FIGS %L\n" length(cv->figs)))
errset(printf("AP-CV-FIGURES %L\n" length(cv->figures)))
errset(printf("AP-CV-NETS %L\n" length(cv->nets)))
errset(printf("AP-CV-TERMS %L\n" length(cv->terms)))
errset(printf("AP-CV-PROPS %L\n" cv->props))
errset(printf("AP-CV-NAME %L\n" cv->name))
errset(printf("AP-CV-VIEWTYPE %L\n" cv->viewType))
errset(printf("AP-CV-TECHLIB %L\n" cv->techLib))
errset(printf("AP-CV-CELL %L\n" cv->cell))
inst = car(cv->instances)
printf("AP-FIRST-INST %L\n" inst)
errset(printf("AP-I-NAME %L\n" inst->name))
errset(printf("AP-I-CELLVIEW %L\n" inst->cellView))
errset(printf("AP-I-OBJVIEW %L\n" inst->objView))
errset(printf("AP-I-MODEL %L\n" inst->model))
errset(printf("AP-I-PARAMS %L\n" inst->params))
errset(printf("AP-I-PROPS %L\n" inst->props))
errset(printf("AP-I-INSTERMS %L\n" inst->instTerms))
errset(printf("AP-I-TERMCONN %L\n" inst->termConnections))
net = car(cv->nets)
printf("AP-FIRST-NET %L\n" net)
errset(printf("AP-N-NAME %L\n" net->name))
errset(printf("AP-N-INSTERMS %L\n" net->instTerms))
errset(printf("AP-N-FIGTERMS %L\n" net->figTerms))
errset(printf("AP-N-WIRES %L\n" net->wires))
errset(printf("AP-N-DIR %L\n" net->direction))
term = car(cv->terms)
printf("AP-FIRST-TERM %L\n" term)
errset(printf("AP-T-NAME %L\n" term->name))
errset(printf("AP-T-DIR %L\n" term->direction))
errset(printf("AP-T-WIRES %L\n" term->wires))
dbClose(cv)
printf("AP_DONE\n")
exit()
