printf("PLAIN_RESULT %L\n" car(hiGetWindowList())->name)
printf("AFTER %L\n" 1)
