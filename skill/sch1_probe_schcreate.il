printf("SCH_ROW %L\n" schCreate("microled_cells", "s7b", "schematic", "schematic"))
printf("AFTER %L\n" 1)
