;; sc1_s3c4_apply.il -- GENERATED by scripts/sc1_s3c4_fix_labels.py; do not hand-edit.
;;
;; Rows come from the pairing table, and every object is found by DATABASE RELATIONSHIP,
;; not by coordinate guessing: the label to move is the child of this terminal's own pin
;; figure whose theLabel equals the terminal name; the stale stub to delete is the line on
;; device/drawing whose endpoints equal the recorded old ones. Pin rectangles, terminals,
;; directions, nets, the cell-name label and the "[@instanceName]" text are never touched.
;; NEW_SIMULATION_RUNS = 0.

s4Lib = "microled_scan_s3c"
s4Copies = nil
s4Jobs = list(
  list("c2mos_dff" "c2mos_dff")
  list("sc1_ls_c1_r2d" "sc1_ls_c1_r2d")
  list("sc1_ls_c1_top_r2d" "sc1_ls_c1_top_r2d")
  list("sc1_ls_core_r2d" "sc1_ls_core_r2d")
  list("sc1_r3_scan_chain_1ch" "sc1_r3_scan_chain_1ch")
  list("sc1_s3b_p33_bank_7" "sc1_s3b_p33_bank_7")
  list("sc1_scan_gate" "sc1_scan_gate")
  list("sc1_scan_power_1ch_s3c" "sc1_scan_power_1ch_s3c")
)
s4Moves = list(
  list("c2mos_dff" "d" -0.9 0.0)
  list("c2mos_dff" "q" 0.0875 0.2625)
  list("c2mos_dff" "qbar" 0.08125 -0.2375)
  list("c2mos_dff" "vdd" 0.075 0.80625)
  list("c2mos_dff" "vss" -0.36875 -0.81875)
  list("sc1_ls_c1_r2d" "core_ok33" -0.39375 0.375)
  list("sc1_ls_c1_r2d" "gate33" 0.08125 0.0125)
  list("sc1_ls_c1_r2d" "vdd33" -0.61875 -0.0625)
  list("sc1_ls_c1_r2d" "vss" -0.68125 -0.56875)
  list("sc1_ls_c1_top_r2d" "core_ok33" -0.575 0.5)
  list("sc1_ls_c1_top_r2d" "en" -1.85 -0.125)
  list("sc1_ls_c1_top_r2d" "gate33" 0.08125 0.13125)
  list("sc1_ls_c1_top_r2d" "vdd18" -0.6125 0.30625)
  list("sc1_ls_c1_top_r2d" "vdd33" 0.125 0.05625)
  list("sc1_ls_c1_top_r2d" "vss" -0.86875 -0.81875)
  list("sc1_ls_core_r2d" "vdd18" -0.425 0.30625)
  list("sc1_ls_core_r2d" "vdd33" 0.125 0.05625)
  list("sc1_ls_core_r2d" "vss" -0.68125 -0.81875)
  list("sc1_ls_core_r2d" "x" 0.8375 0.5)
  list("sc1_ls_core_r2d" "y" 0.0875 0.00625)
  list("sc1_r3_scan_chain_1ch" "blank" -0.925 0.875)
  list("sc1_r3_scan_chain_1ch" "clk" -2.0875 0.125)
  list("sc1_r3_scan_chain_1ch" "core_ok33" 0.3625 0.0)
  list("sc1_r3_scan_chain_1ch" "gate33" 0.08125 -0.1125)
  list("sc1_r3_scan_chain_1ch" "vdd18" 0.125 0.05625)
  list("sc1_r3_scan_chain_1ch" "vdd33" -1.13125 0.18125)
  list("sc1_r3_scan_chain_1ch" "vss" -0.99375 -1.06875)
  list("sc1_s3b_p33_bank_7" "bgate" 0.15 0.0125)
  list("sc1_s3b_p33_bank_7" "scan" 0.0875 0.0)
  list("sc1_s3b_p33_bank_7" "vscan" 0.125 0.06875)
  list("sc1_scan_gate" "blank" -0.4875 0.375)
  list("sc1_scan_gate" "en" 0.08125 0.0)
  list("sc1_scan_gate" "qbar" 0.1125 0.00625)
  list("sc1_scan_gate" "vdd" -0.55 -0.0625)
  list("sc1_scan_gate" "vss" -0.55625 -0.56875)
  list("sc1_scan_power_1ch_s3c" "blank" -0.5875 -0.125)
  list("sc1_scan_power_1ch_s3c" "clk" -1.0875 0.625)
  list("sc1_scan_power_1ch_s3c" "core_ok33" 0.3625 0.0)
  list("sc1_scan_power_1ch_s3c" "scan" 0.0875 0.0)
  list("sc1_scan_power_1ch_s3c" "vdd18" -0.6 0.43125)
  list("sc1_scan_power_1ch_s3c" "vdd33" 0.125 0.05625)
  list("sc1_scan_power_1ch_s3c" "vscan" -1.40625 0.19375)
  list("sc1_scan_power_1ch_s3c" "vss" -1.05625 -1.06875)
)
s4Stubs = list(
  list("c2mos_dff" "add" -0.56250 0.12500 -0.68750 0.12500)
  list("c2mos_dff" "add" -0.56250 -0.12500 -0.68750 -0.12500)
  list("c2mos_dff" "del" 0.56250 -0.12500 0.68750 -0.12500)
  list("c2mos_dff" "del" 0.56250 0.12500 0.68750 0.12500)
  list("sc1_ls_c1_r2d" "add" -0.87500 0.12500 -1.00000 0.12500)
  list("sc1_ls_c1_r2d" "del" 0.87500 0.12500 1.00000 0.12500)
  list("sc1_ls_c1_top_r2d" "add" -1.06250 0.12500 -1.18750 0.12500)
  list("sc1_ls_c1_top_r2d" "add" -1.06250 -0.12500 -1.18750 -0.12500)
  list("sc1_ls_c1_top_r2d" "del" 1.06250 0.12500 1.18750 0.12500)
  list("sc1_ls_c1_top_r2d" "del" 1.06250 -0.12500 1.18750 -0.12500)
  list("sc1_r3_scan_chain_1ch" "add" -1.18750 0.37500 -1.31250 0.37500)
  list("sc1_r3_scan_chain_1ch" "add" -1.18750 0.12500 -1.31250 0.12500)
  list("sc1_r3_scan_chain_1ch" "del" 1.18750 0.37500 1.31250 0.37500)
  list("sc1_r3_scan_chain_1ch" "del" 1.18750 0.12500 1.31250 0.12500)
  list("sc1_scan_gate" "add" -0.75000 0.12500 -0.87500 0.12500)
  list("sc1_scan_gate" "del" 0.75000 0.12500 0.87500 0.12500)
  list("sc1_scan_power_1ch_s3c" "add" -1.25000 0.37500 -1.37500 0.37500)
  list("sc1_scan_power_1ch_s3c" "add" -1.25000 0.12500 -1.37500 0.12500)
  list("sc1_scan_power_1ch_s3c" "del" 1.25000 0.37500 1.37500 0.37500)
  list("sc1_scan_power_1ch_s3c" "del" 1.25000 0.12500 1.37500 0.12500)
)

procedure(s4Val(v) if(v v "NONE"))
procedure(s4Target(job) nth(1 job))

procedure(s4FindLabel(cv term)
  let((res p f ch) ;; the text object drawn for this terminal's own pin figure
    res = nil
    foreach(tm cv~>terminals
      when(equal(tm~>name term)
        foreach(p tm~>pins
          foreach(f p~>figs
            foreach(ch dbGet(f 'children)
              when(and(res == nil equal(s4Val(dbGet(ch 'theLabel)) term)
                       or(equal(ch~>objType "label") equal(ch~>objType "textDisplay")))
                res = ch
              )
            )
          )
        )
      )
    )
    res
  )
)

procedure(s4FindLine(cv a b)
  let((res pts) ;; exact endpoint match, either order; the SKILL side does no arithmetic
    res = nil
    foreach(s cv~>shapes
      when(and(res == nil equal(s~>objType "line")
               equal(s4Val(dbGet(s 'layerName)) "device")
               equal(s4Val(dbGet(s 'purpose)) "drawing"))
        pts = dbGet(s 'points)
        when(and(pts equal(pts list(a b))) res = s)
        when(and(pts res == nil equal(pts list(b a))) res = s)
      )
    )
    res
  )
)

printf("S4-BEGIN jobs=%L moves=%L stubs=%L\n" length(s4Jobs) length(s4Moves) length(s4Stubs))
when(s4Copies
  foreach(cp s4Copies
    src = car(errset(dbOpenCellViewByType(s4Lib nth(0 cp) "symbol" nil "r")))
    new = car(errset(dbCopyCellView(src s4Lib nth(1 cp) "symbol" "symbol")))
    printf("S4-COPY %L -> %L made=%L\n" nth(0 cp) nth(1 cp) s4Val(new != nil))
    errset(dbClose(src))
  )
)
foreach(job s4Jobs
  cell = s4Target(job)
  plan = nth(0 job)
  cv = car(errset(dbOpenCellViewByType(s4Lib cell "symbol" nil "a")))
  when(cv
    foreach(st s4Stubs
      when(and(equal(nth(0 st) plan) equal(nth(1 st) "del"))
        a = list(nth(2 st) nth(3 st))
        b = list(nth(4 st) nth(5 st))
        f = s4FindLine(cv a b)
        printf("S4-STUB-DEL %L pts=(%L %L %L %L) found=%L deleted=%L\n"
               cell nth(2 st) nth(3 st) nth(4 st) nth(5 st) s4Val(f != nil)
               s4Val(if(f car(errset(dbDeleteObject(f))) nil)))
      )
    )
    foreach(st s4Stubs
      when(and(equal(nth(0 st) plan) equal(nth(1 st) "add"))
        g = car(errset(dbCreateLine(cv list("device" "drawing")
                                    list(list(nth(2 st) nth(3 st)) list(nth(4 st) nth(5 st))))))
        printf("S4-STUB-ADD %L pts=(%L %L %L %L) made=%L bbox=%L\n"
               cell nth(2 st) nth(3 st) nth(4 st) nth(5 st) s4Val(g != nil)
               s4Val(dbGet(g 'bBox)))
      )
    )
    foreach(mv s4Moves
      when(equal(nth(0 mv) plan)
        lab = s4FindLabel(cv nth(1 mv))
        when(lab
          before = dbGet(lab 'xy)
          ok = car(errset(dbMoveFig(lab cv list(list(nth(2 mv) nth(3 mv)) "R0" 1.0))))
          printf("S4-MOVE %L %L from=%L delta=(%L %L) moved=%L text=%L now=%L\n"
                 cell nth(1 mv) s4Val(before) nth(2 mv) nth(3 mv) s4Val(ok)
                 s4Val(dbGet(lab 'theLabel)) s4Val(dbGet(lab 'xy)))
        )
        unless(lab printf("S4-SKIP %L %L no owned label found\n" cell nth(1 mv)))
      )
    )
    errset(dbSave(cv))
    printf("S4-SAVED %L\n" cell)
    errset(dbClose(cv))
    printf("S4-CLOSED %L\n" cell)
  )
  unless(cv printf("S4-OPENFAIL %L\n" cell))
)
printf("S4-DONE\n")
nil
