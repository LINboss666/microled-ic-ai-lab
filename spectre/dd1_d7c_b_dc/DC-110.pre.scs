// DC-110.scs -- DATA-7C-B-PREP-R1 deck for case DC-110. TEXT ONLY, NEVER RUN.
// DERIVED BY DATA-7C-B-DC FOR THE PREFLIGHT OF DC-110: the one DUT line is replaced by the two meter loads
// below and the five hierarchical saves of the DUT are dropped because no DUT exists here. Sources, the 19-point
// clamp grid, the analysis line and the probe are byte-identical to the delivered deck.
// The inherited first line describes the preparation round that only wrote the text; under the user
// approval of DATA-7C-B-DC this case does run, accounted against a ceiling of 20 processes.
//
// Generated by scripts/dd1_d7c_b_prep_deckgen.py from tests/dd1_d7c_b_prep/contract.json and
// tests/dd1_d7c_b_prep/schedule.csv. Do not edit this file by hand: change the source and
// regenerate, otherwise the schedule and the deck disagree, which is the defect this round
// exists to remove. Contract state: PROPOSED_FOR_REVIEW (not USER_APPROVED).
// Authorisation: NEW_SPECTRE_LAUNCH_LIMIT=0, NATIVE_PREFLIGHT_AUTHORISED=NO,
// NEXT_NATIVE_STAGE_AUTHORISED=NO. Nothing in this file has been run, and running it is not
// authorised by this round. NATIVE_NETLIST_SYNTAX=NOT_VERIFIED: the analysis and pwl forms
// below are the ones this project has already run (scripts/dd1_d7b_run.py:239 and :288,
// spectre/current_probe_syntax.scs:35), but hierarchical saves are still unproven on them.
//
// ---- this case, in numbers -------------------------------------------------------
// class                 : dc_sweep
// pam_sel               : 110  (pam0=bit0 weight 1, pam1=bit1 weight 2, pam2=bit2 weight 4)
// DATA_EN form          : static_dc at 1.800 V (the 1.800 V logic domain, never the bit itself)
// temperature           : simopt options temp=27, written as a statement in this deck
// supplies              : vdd18=1.8 V, vcas=1.8 V, vss=explicit 0 V source, Iref=1.5e-05 A (the deck writes it as 15u)
// output clamp          : 1.2 V (POC condition, not VLED, not VSCAN, not SOA)
// clamp sweep         : 0.600,0.650,0.700,0.750,0.800,0.850,0.900,0.950,1.000,1.050,1.100,1.150,1.200,1.250,1.300,1.350,1.400,1.450,1.500
// analysis            : dc_case dc dev=Vclamp param=dc start=0.600 stop=1.500 step=0.050
// nominal for this code: 13.125 uA, identity ESTIMATED_MIRROR_RATIO_ONLY
// windows declared for this case: DC-110#SWEEP
//
// ---- probe and sign, fixed before any run -------------------------------------------------
// Ip_branch (clamp_node data_out) iprobe, so a positive reading IS the selected branches
// sinking current out of data_out: I_sink = Ip_branch, with no negation and no abs(). The
// physical positive path is clamp_node -> data_out -> the conducting branch(es) -> vss, which
// is the same terminal order the accepted DATA-7B bench uses. A shutoff tail keeps its own
// sign: Q, Qpos and the magnitude of Qneg are reported separately and never cancel.
simulator lang=spectre insensitive=yes

// PDK path and model section come from the environment; no model card is copied into this
// repository and none was read this round.
include "${QODER_PDK_LIB}" section=tt
// the temperature is a deck condition, not a contract adjective
simopt options temp=27

include "${QODER_NETLIST_DIR}/dd1_d6_inv18.scs"
include "${QODER_NETLIST_DIR}/dd1_d6_bias_core.scs"
include "${QODER_NETLIST_DIR}/dd1_d7c_a_gates.scs"
include "${QODER_NETLIST_DIR}/dd1_d7c_a_pam_dec.scs"
include "${QODER_NETLIST_DIR}/dd1_d7c_a_sink_unit.scs"
include "${QODER_NETLIST_DIR}/dd1_d7c_a_pam_top.scs"

// ---- the device under test: one output, eight selectable branches (delivered, unmodified)
Rload_meter (data_out vss) resistor r=80e3
Rref_meter (iref_in vss) resistor r=50e3

// ---- testbench side: reference and supplies, every node referenced to a real 0 V
Iref_in (irefbus iref_in) isource dc=15u
Viref (irefbus 0) vsource dc=0
Vdd18 (vdd18 0) vsource dc=1.8
Vss (vss 0) vsource dc=0
Vcas (vcas 0) vsource dc=1.8
// The swept node. The 1.2 V evaluation point has to be one of these points, and it is:
// 1.2 is an exact member of the grid.
Vclamp (clamp_node 0) vsource dc=1.2
// DATA_EN is a static level here: an absolute-current point measured with the branches
// off would be a point about nothing.
Vdata_en (data_en 0) vsource dc=1.800
VPAM0 (pam0 0) vsource dc=0.000   // bit weight 1 of code 110
VPAM1 (pam1 0) vsource dc=1.800   // bit weight 2 of code 110
VPAM2 (pam2 0) vsource dc=1.800   // bit weight 4 of code 110

// ---- observation points. Hierarchical saves are NOT_VERIFIED on this build; if the native
// stage refuses them the fallback is to lift the node in a draft copy of the unit subckt,
// never to edit the delivered candidate.
Ip_branch (clamp_node data_out) iprobe
save vdd18 vss iref_in vcas data_out clamp_node irefbus data_en pam0 pam1 pam2
save Ip_branch Ip_branch:current

dc_case dc dev=Vclamp param=dc start=0.600 stop=1.500 step=0.050

// result column for this case in tests/dd1_d7c_b_prep/schedule.csv: NOT_RUN
