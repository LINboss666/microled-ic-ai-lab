// ddrv_D_local_tran -- generated by scripts/ddrv_gen.py (candidate D_local, 2 channel(s)).
// Rework of the accepted 15 uA cascode core: same Mout + Mcas, same W/L, same current.
// What changed is only WHERE the enable acts: DATA_EN drives the cascode gate, so each
// channel cuts its own path and the shared VBIAS stays up. The previous structure bled
// the shared gate to 0, which cannot work once channels are switched independently.
// Direction: low-side SINK to VSS (ENGINEERING_TOPOLOGY_CHOICE). Vf / VLED: NOT DEFINED,
// so V(DATA_OUT) is a swept test variable and no LED model exists here.
// The 15 uA reference is an ideal source -> TESTBENCH ASSUMPTION; its 15 uA is shared
// bias overhead while any channel is off, reported but not a blocker this round.
simulator lang=spectre insensitive=yes

include "${QODER_PDK_LIB}" section=tt

parameters IREF=15u VDDV=1.8 RSEN=1e4

* ---- shared bias, always on -------------------------------------------------
Mref (vbias vbias vss vss) n33 l=2e-6 w=2e-5
Iref (vdd vbias) isource dc=IREF

* Rails: `vss` is tied to the Spectre reference node 0 explicitly -- a floating vss once
* produced a whole simulation series of "all PMOS working, every NMOS dead" with 0 errors.
Vdd (vdd 0) vsource dc=VDDV
Vss (vss 0) vsource dc=0

* ---- channel 0: the 2 MOS that every channel must repeat ----------------------
Mcas (data_out data_en node_m vss) n33 l=2e-6 w=2e-5
Mout (node_m  vbias     vss     vss) n33 l=2e-6 w=2e-5
Vout (vsw 0)      vsource dc=1.2
Rsen (data_out vsw) resistor r=RSEN

* ---- channel 1: the 2 MOS that every channel must repeat ----------------------
Mcas1 (data_out1 data_en1 node_m1 vss) n33 l=2e-6 w=2e-5
Mout1 (node_m1  vbias     vss     vss) n33 l=2e-6 w=2e-5
Vout1 (vsw1 0)      vsource dc=1.2
Rsen1 (data_out1 vsw1) resistor r=RSEN
Vde (data_en 0) vsource type=pulse val0=0 val1=VDDV period=TD \
                    delay=0.25*TD width=0.5*TD rise=1e-9 fall=1e-9
Vde1 (data_en1 0) vsource dc=VDDV
parameters TD=9.765625e-6

save vdd vss vsw data_out vbias node_m data_en vsw1 data_out1 node_m1 data_en1

tran1 tran stop=4.39453125e-05 step=4.8828125e-09
