// ddrv_E_local_gate_tran -- generated by scripts/ddrv_gen.py (2 channel(s)).
// Accepted core, unchanged: Mout + Mcas, n33, W=2e-5 L=2e-6, cascode gate at 1.8 V.
// Rework under test: each channel owns its mirror gate node `vbias_ch`. DATA_EN drives a
// local pass device to VBIAS_SHARED; DATA_EN_B drives a local bleed to VSS. No channel can
// bleed the shared node -- that was the fatal property of the shared-gate structure (C) and
// the residual dynamic coupling of the cascode-gate variant (D).
// Direction: low-side SINK to VSS (ENGINEERING_TOPOLOGY_CHOICE). Vf / VLED: NOT DEFINED, so
// V(DATA_OUT) stays a swept test variable and no LED model is invented here.
// ideal IREF / VCAS / DATA_EN / DATA_EN_B: TESTBENCH ASSUMPTIONS (POC_ASSUMPTION).
simulator lang=spectre insensitive=yes

include "${QODER_PDK_LIB}" section=ss

* ---- cellviews exported from OA by scripts/sch3_deck_from_oa.py (hier) ----
subckt data_bias_ref (VBIAS_SHARED VSS)
  Mref (VBIAS_SHARED VBIAS_SHARED VSS VSS) n33 l=2e-06 w=2e-05
ends data_bias_ref

subckt data_sink_1ch (DATA_EN DATA_EN_B VBIAS_SHARED VCAS DATA_OUT VSS)
  Mbleed_local (vbias_ch DATA_EN_B VSS VSS) n33 l=2e-06 w=2e-06
  Mcas (DATA_OUT VCAS node_m VSS) n33 l=2e-06 w=2e-05
  Mout (node_m vbias_ch VSS VSS) n33 l=2e-06 w=2e-05
  Mpass_local (VBIAS_SHARED DATA_EN vbias_ch vbias_ch) n33_dnw_4t_ckt l=2e-06 w=5e-06
ends data_sink_1ch

Xc (data_en data_en_b vbias vcas data_out vss) data_sink_1ch
Xc1 (data_en1 data_en_b1 vbias vcas1 data_out1 vss) data_sink_1ch
Xb (vbias vss) data_bias_ref

parameters IREF=15u VDDV=1.8 VCASV=1.8

* ---- shared bias: always on, never bled by any channel ------------------------
Iref (vdd vbias) isource dc=IREF

* `vss` tied to the Spectre reference node 0 on purpose (AGENTS item 19).
Vdd (vdd 0) vsource dc=VDDV
Vss (vss 0) vsource dc=0

* ---- channel 0: 2 core MOS + 2 local gate-control MOS ----------------------
* E-DNW: the pass device is a deep-N-well master, so vbias_ch really is this channel's own
* isolated body and tying it to the source (VBS = 0) is manufacturable
Vcas  (vcas  0) vsource dc=VCASV
Vout  (vsw   0) vsource dc=1.20
Ip1 (vsw data_out) iprobe

* ---- channel 1: 2 core MOS + 2 local gate-control MOS ----------------------
* E-DNW: the pass device is a deep-N-well master, so vbias_ch1 really is this channel's own
* isolated body and tying it to the source (VBS = 0) is manufacturable
Vcas1  (vcas1  0) vsource dc=VCASV
Vout1  (vsw1   0) vsource dc=1.20
Ip2 (vsw1 data_out1) iprobe

save Ip1:i Ip2:i
save Mout:1 Mout1:1

save vdd vss vbias vsw data_out data_en data_en_b vcas vsw1 data_out1 data_en1 data_en_b1 vcas1

parameters TD=9.765625e-6
Vde  (data_en 0)   vsource type=pulse val0=0    val1=VDDV period=TD \
                     delay=0.25*TD width=0.5*TD rise=1e-8 fall=1e-8
Vdeb (data_en_b 0) vsource type=pulse val0=VDDV val1=0    period=TD \
                     delay=0.25*TD width=0.5*TD rise=1e-8 fall=1e-8
Vde1 (data_en1 0) vsource dc=VDDV
Vdeb1 (data_en_b1 0) vsource dc=0

tran1 tran stop=4.39453e-05 step=4.88281e-09 maxstep=5e-09 method=gear2only
