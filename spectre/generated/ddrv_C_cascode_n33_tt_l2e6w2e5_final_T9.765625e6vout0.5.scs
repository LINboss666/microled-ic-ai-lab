// ddrv_C_cascode_tran -- generated by scripts/ddrv_gen.py; one channel of the Micro LED data driver.
// Course requirement (the only formal current target): I_PIXEL_ON = 15 uA, defined as the
//   instantaneous pixel current while the Micro LED is selected and ON, not a frame average.
// Direction: current SINK to VSS. Micro LED Vf and the VLED domain stay NOT DEFINED, so no
//   LED model exists here: V(DATA_OUT) is swept as an independent DC test variable and the
//   answer reported is the output compliance / minimum headroom, never a claimed workload.
// The 15 uA reference is an ideal source -> TESTBENCH ASSUMPTION, not a channel device.
simulator lang=spectre insensitive=yes

include "${QODER_PDK_LIB}" section=tt

parameters IREF=15u VDDV=1.8 RSEN=1e4

* ---- shared bias branch (not part of the per-channel count) --------------------
* ideal 15 uA into a diode-connected device of the SAME geometry as the output
* device, so the mirror ratio is 1:1 and any error is channel-length modulation
* plus the switch, not a sizing ratio. The diode always sits between its gate node
* and VSS; what differs between candidates is what feeds it.
Mref (vbias vbias vss vss) n33 l=2e-6 w=2e-5
Iref (vdd ref_top) isource dc=IREF

* ---- channel: candidate C_cascode (2 devices carry the current) --------------
Mout (node_m vbias vss vss)   n33 l=2e-6 w=2e-5
Mcas (data_out vcas node_m vss) n33 l=2e-6 w=2e-5

* shared bias block, identical to B_gate: pass device, dummy that takes the 15 uA while
* disabled, and a bleed that holds the mirror gate at 0 so the stack really turns off.
Msteer  (ref_top data_en vbias vbias) n33 l=2e-6 w=2e-5
Mdummy  (ref_top data_en_b vss vss)       n33 l=2e-6 w=2e-5
Mbleed  (vbias data_en_b vss vss)       n33 l=2e-6 w=2e-5

* ---- rails, the output test source and a known sense resistor -----------------
* `vss` is tied to the Spectre reference node 0 explicitly: an earlier round of this
* project wasted a whole simulation series on a floating `vss` that Spectre still
* reported as "0 errors".
* IOUT comes from the drop across RSEN, not from `save *:current`: this build answers
* that with SPECTRE-8059/8287 warnings, and shipping a run whose warnings were waved
* away is what the review rules forbid.
Vdd  (vdd 0)      vsource dc=VDDV
Vss  (vss 0)      vsource dc=0
Vout (vsw 0)      vsource dc=0.5
Rsen (data_out vsw) resistor r=RSEN
Vcas (vcas 0) vsource dc=1.8

save vdd vss vsw data_out vbias node_m vcas data_en

parameters TD=9.765625e-6

Vde   (data_en 0)   vsource type=pulse val0=0 val1=VDDV period=TD width=0.5*TD \
                    delay=0.25*TD rise=1e-9 fall=1e-9
Vdeb  (data_en_b 0) vsource type=pulse val0=VDDV val1=0 period=TD width=0.5*TD \
                    delay=0.25*TD rise=1e-9 fall=1e-9

tran1 tran stop=4.39453125e-05 step=4.8828125e-09
