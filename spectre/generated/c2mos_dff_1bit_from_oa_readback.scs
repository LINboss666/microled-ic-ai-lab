; SCH-2: netlist rebuilt from the OA cellview c2mos_dff_1bit (readback rows only).
; Input file: cadence_work/logs/sch_nograph_20261011_200240.log -- generated by skill/sch2_readback.il against the saved schematic.
; l= and w= are the numbers the database itself resolved; nothing here is read from
; spectre/C2MOS_DFF.scs.
simulator lang=spectre insensitive=yes

subckt c2mos_dff_1bit (d clk q qbar vdd vss)
  mn_c (clkb clk vss vss) n18 l=2e-07 w=2e-06
  mn_k1 (mb m vss vss) n18 l=2e-07 w=5e-07
  mn_k2 (m mb vss vss) n18 l=2e-07 w=5e-07
  mn_k3 (qbar q vss vss) n18 l=2e-07 w=5e-07
  mn_k4 (q qbar vss vss) n18 l=2e-07 w=5e-07
  mn_m1 (x2 clkb vss vss) n18 l=2e-07 w=2e-06
  mn_m2 (m d x2 vss) n18 l=2e-07 w=2e-06
  mn_s1 (y2 clk vss vss) n18 l=2e-07 w=2e-06
  mn_s2 (q m y2 vss) n18 l=2e-07 w=2e-06
  mp_c (clkb clk vdd vdd) p18 l=2e-07 w=4e-06
  mp_k1 (mb m vdd vdd) p18 l=2e-07 w=1e-06
  mp_k2 (m mb vdd vdd) p18 l=2e-07 w=1e-06
  mp_k3 (qbar q vdd vdd) p18 l=2e-07 w=1e-06
  mp_k4 (q qbar vdd vdd) p18 l=2e-07 w=1e-06
  mp_m1 (x1 clk vdd vdd) p18 l=2e-07 w=4e-06
  mp_m2 (m d x1 vdd) p18 l=2e-07 w=4e-06
  mp_s1 (y1 clkb vdd vdd) p18 l=2e-07 w=4e-06
  mp_s2 (q m y1 vdd) p18 l=2e-07 w=4e-06
ends c2mos_dff_1bit
