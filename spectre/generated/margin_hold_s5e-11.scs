// GENERATED by scripts/c2mos_margin.sh -- mode=hold T=2e-7 slew=5e-11 VTH=0.9
// one instance per margin; identical cells, identical loads, shared clock.
// PRELIMINARY characterisation: tt corner, one VDD, one temperature, 50 fF.
simulator lang=spectre insensitive=yes
include "${QODER_PDK_LIB}" section=tt
include "C2MOS_DFF.scs"

Vdd (vdd 0) vsource dc=1.8
Vss (vss 0) vsource dc=0
Ck (clk 0) vsource type=pulse val0=0 val1=1.8 period=2e-7 delay=1e-07 width=1e-07 rise=5e-11 fall=5e-11

D0 (d0 0) vsource type=pulse val0=0 val1=1.8 period=1 delay=4e-08 width=4.7995e-07 rise=5e-11 fall=5e-11
X0 (d0 clk q0 qb0 vdd vss) c2mos_dff
Cq0  (q0  0) capacitor c=50e-15
Cqb0 (qb0 0) capacitor c=50e-15
save d0 q0
D1 (d1 0) vsource type=pulse val0=0 val1=1.8 period=1 delay=4e-08 width=4.6995e-07 rise=5e-11 fall=5e-11
X1 (d1 clk q1 qb1 vdd vss) c2mos_dff
Cq1  (q1  0) capacitor c=50e-15
Cqb1 (qb1 0) capacitor c=50e-15
save d1 q1
D2 (d2 0) vsource type=pulse val0=0 val1=1.8 period=1 delay=4e-08 width=4.6495e-07 rise=5e-11 fall=5e-11
X2 (d2 clk q2 qb2 vdd vss) c2mos_dff
Cq2  (q2  0) capacitor c=50e-15
Cqb2 (qb2 0) capacitor c=50e-15
save d2 q2
D3 (d3 0) vsource type=pulse val0=0 val1=1.8 period=1 delay=4e-08 width=4.6295e-07 rise=5e-11 fall=5e-11
X3 (d3 clk q3 qb3 vdd vss) c2mos_dff
Cq3  (q3  0) capacitor c=50e-15
Cqb3 (qb3 0) capacitor c=50e-15
save d3 q3
D4 (d4 0) vsource type=pulse val0=0 val1=1.8 period=1 delay=4e-08 width=4.6195e-07 rise=5e-11 fall=5e-11
X4 (d4 clk q4 qb4 vdd vss) c2mos_dff
Cq4  (q4  0) capacitor c=50e-15
Cqb4 (qb4 0) capacitor c=50e-15
save d4 q4
D5 (d5 0) vsource type=pulse val0=0 val1=1.8 period=1 delay=4e-08 width=4.6145e-07 rise=5e-11 fall=5e-11
X5 (d5 clk q5 qb5 vdd vss) c2mos_dff
Cq5  (q5  0) capacitor c=50e-15
Cqb5 (qb5 0) capacitor c=50e-15
save d5 q5
D6 (d6 0) vsource type=pulse val0=0 val1=1.8 period=1 delay=4e-08 width=4.6095e-07 rise=5e-11 fall=5e-11
X6 (d6 clk q6 qb6 vdd vss) c2mos_dff
Cq6  (q6  0) capacitor c=50e-15
Cqb6 (qb6 0) capacitor c=50e-15
save d6 q6
D7 (d7 0) vsource type=pulse val0=0 val1=1.8 period=1 delay=4e-08 width=4.6065e-07 rise=5e-11 fall=5e-11
X7 (d7 clk q7 qb7 vdd vss) c2mos_dff
Cq7  (q7  0) capacitor c=50e-15
Cqb7 (qb7 0) capacitor c=50e-15
save d7 q7
D8 (d8 0) vsource type=pulse val0=0 val1=1.8 period=1 delay=4e-08 width=4.6035e-07 rise=5e-11 fall=5e-11
X8 (d8 clk q8 qb8 vdd vss) c2mos_dff
Cq8  (q8  0) capacitor c=50e-15
Cqb8 (qb8 0) capacitor c=50e-15
save d8 q8
D9 (d9 0) vsource type=pulse val0=0 val1=1.8 period=1 delay=4e-08 width=4.6015e-07 rise=5e-11 fall=5e-11
X9 (d9 clk q9 qb9 vdd vss) c2mos_dff
Cq9  (q9  0) capacitor c=50e-15
Cqb9 (qb9 0) capacitor c=50e-15
save d9 q9
D10 (d10 0) vsource type=pulse val0=0 val1=1.8 period=1 delay=4e-08 width=4.5995e-07 rise=5e-11 fall=5e-11
X10 (d10 clk q10 qb10 vdd vss) c2mos_dff
Cq10  (q10  0) capacitor c=50e-15
Cqb10 (qb10 0) capacitor c=50e-15
save d10 q10
D11 (d11 0) vsource type=pulse val0=0 val1=1.8 period=1 delay=4e-08 width=4.5955e-07 rise=5e-11 fall=5e-11
X11 (d11 clk q11 qb11 vdd vss) c2mos_dff
Cq11  (q11  0) capacitor c=50e-15
Cqb11 (qb11 0) capacitor c=50e-15
save d11 q11
D12 (d12 0) vsource type=pulse val0=0 val1=1.8 period=1 delay=4e-08 width=4.5895e-07 rise=5e-11 fall=5e-11
X12 (d12 clk q12 qb12 vdd vss) c2mos_dff
Cq12  (q12  0) capacitor c=50e-15
Cqb12 (qb12 0) capacitor c=50e-15
save d12 q12

save clk
tr1 tran stop=7e-07 maxstep=2e-11
