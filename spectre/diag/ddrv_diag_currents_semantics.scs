// ddrv_diag_currents_semantics.scs -- DIAGNOSTIC, not a candidate deck.
// Derived from the Candidate E transient deck by replacing `save Mout:1` with every terminal
// current of the stack (Mcas/Mout/Mpass_local/Mref). Purpose: settle what the saved traces
// actually mean before any transient number is interpreted. Measured result on this build:
// at the settled ON point the probe branch reads 1.386e-05 A while `Mcas:1` reads
// 1.383e-05 A and `Mcas:2` (the GATE terminal) carries -8.6e-07 A, i.e. this PDK's n33 model
// has real DC gate and bulk terminal currents. Therefore `Ip*:i` (the wire current the pixel
// sees) and `Mout:1` (a device terminal current) are different quantities in a transient and
// must not be averaged together; `Mout:1` is kept only as a DC cross-check.
// Simulator command used on the guest:
//   bash scripts/run_spectre.sh /root/microled_ai_project/spectre/diag/ddrv_diag_currents_semantics.scs 300
// (run_spectre.sh requires an absolute path under the project root.)
// Original generated header, kept for provenance:
// ddrv_E_local_gate_tran -- generated by scripts/ddrv_gen.py (1 channel(s)).

// Accepted core, unchanged: Mout + Mcas, n33, W=2e-5 L=2e-6, cascode gate at 1.8 V.
// Rework under test: each channel owns its mirror gate node `vbias_ch`. DATA_EN drives a
// local pass device to VBIAS_SHARED; DATA_EN_B drives a local bleed to VSS. No channel can
// bleed the shared node -- that was the fatal property of the shared-gate structure (C) and
// the residual dynamic coupling of the cascode-gate variant (D).
// Direction: low-side SINK to VSS (ENGINEERING_TOPOLOGY_CHOICE). Vf / VLED: NOT DEFINED, so
// V(DATA_OUT) stays a swept test variable and no LED model is invented here.
// ideal IREF / VCAS / DATA_EN / DATA_EN_B: TESTBENCH ASSUMPTIONS (POC_ASSUMPTION).
simulator lang=spectre insensitive=yes

include "${QODER_PDK_LIB}" section=tt

parameters IREF=15u VDDV=1.8 VCASV=1.8

* ---- shared bias: always on, never bled by any channel ------------------------
Mref (vbias vbias vss vss) n33 l=2e-6 w=2e-5
Iref (vdd vbias) isource dc=IREF

* `vss` tied to the Spectre reference node 0 on purpose (AGENTS item 19).
Vdd (vdd 0) vsource dc=VDDV
Vss (vss 0) vsource dc=0

* ---- channel 0: 2 core MOS + 2 local gate-control MOS ----------------------
Mcas   (data_out vcas   node_m vss) n33      l=2e-6  w=2e-5
Mout   (node_m  vbias_ch   vss      vss) n33      l=2e-6  w=2e-5
* body tied to the local node because that is the one that can fall to 0 V
Mpass_local   (vbias   data_en   vbias_ch vbias_ch) n18 l=1e-6 w=2e-5
Mbleed_local (vbias_ch data_en_b vss   vss)  n18  l=1e-6 w=2e-6
Vcas  (vcas  0) vsource dc=VCASV
Vout  (vsw   0) vsource dc=0.50
Ip1 (vsw data_out) iprobe

save Ip1:i
save Mout:1 Mout:2 Mout:3 Mcas:1 Mcas:2 Mcas:3 Mpass_local:1 Mpass_local:3 Mref:1

save vdd vss vbias vsw data_out node_m vbias_ch data_en data_en_b vcas

parameters TD=2e-7
Vde  (data_en 0)   vsource type=pulse val0=0    val1=VDDV period=TD \
                     delay=0.25*TD width=0.5*TD rise=1e-9 fall=1e-9
Vdeb (data_en_b 0) vsource type=pulse val0=VDDV val1=0    period=TD \
                     delay=0.25*TD width=0.5*TD rise=1e-9 fall=1e-9

tran1 tran stop=9e-07 step=1e-10
