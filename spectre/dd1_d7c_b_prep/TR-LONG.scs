// TR-LONG.scs -- DATA-7C-B-PREP-R1 deck for case TR-LONG. TEXT ONLY, NEVER RUN.
//
// Generated by scripts/dd1_d7c_b_prep_deckgen.py from tests/dd1_d7c_b_prep/contract.json and
// tests/dd1_d7c_b_prep/schedule.csv. Do not edit this file by hand: change the source and
// regenerate, otherwise the schedule and the deck disagree, which is the defect this round
// exists to remove. Contract state: PROPOSED_FOR_REVIEW (not USER_APPROVED).
// Authorisation: NEW_SPECTRE_LAUNCH_LIMIT=0, NATIVE_PREFLIGHT_AUTHORISED=NO,
// NEXT_NATIVE_STAGE_AUTHORISED=NO. Nothing in this file has been run, and running it is not
// authorised by this round. NATIVE_NETLIST_SYNTAX=NOT_VERIFIED: the analysis and pwl forms
// below are the ones this project has already run (scripts/dd1_d7b_run.py:239 and :288,
// spectre/current_probe_syntax.scs:35), but hierarchical saves are still unproven on them.
//
// ---- this case, in numbers -------------------------------------------------------
// class                 : transient
// pam_sel               : 000..111  (pam0=bit0 weight 1, pam1=bit1 weight 2, pam2=bit2 weight 4)
// DATA_EN form          : pwl_per_platform at 1.800 V (the 1.800 V logic domain, never the bit itself)
// temperature           : simopt options temp=27, written as a statement in this deck
// supplies              : vdd18=1.8 V, vcas=1.8 V, vss=explicit 0 V source, Iref=1.5e-05 A (the deck writes it as 15u)
// output clamp          : 1.2 V (POC condition, not VLED, not VSCAN, not SOA)
// pure-off preparation: ends at 1000.000 ns; offset applied to every instant of this case: 1050.000 ns; half-edge 50.000 ns
// platform (rise50/fall50): 1050.000;2550.000;4050.000;5550.000;7050.000;8550.000;10050.000;11550.000 / 2050.000;3550.000;5050.000;6550.000;8050.000;9550.000;11050.000;12550.000
// ramp endpoints      : rise 1000.000;2500.000;4000.000;5500.000;7000.000;8500.000;10000.000;11500.000->1100.000;2600.000;4100.000;5600.000;7100.000;8600.000;10100.000;11600.000, fall 2000.000;3500.000;5000.000;6500.000;8000.000;9500.000;11000.000;12500.000->2100.000;3600.000;5100.000;6600.000;8100.000;9600.000;11100.000;12600.000
// full-enable window  : 1050.000;2550.000;4050.000;5550.000;7050.000;8550.000;10050.000;11550.000 -> 2050.000;3550.000;5050.000;6550.000;8050.000;9550.000;11050.000;12550.000 (rise50 to fall50; the charge convergence compares)
// flat part           : 1100.000;2600.000;4100.000;5600.000;7100.000;8600.000;10100.000;11600.000 -> 2000.000;3500.000;5000.000;6500.000;8000.000;9500.000;11000.000;12500.000 (the mean current and the sign rule)
// tail charge window  : 2050.000;3550.000;5050.000;6550.000;8050.000;9550.000;11050.000;12550.000 -> 2500.000;4000.000;5500.000;7000.000;8500.000;10000.000;11500.000;13050.000
// pure-off window     : 2100.000;3600.000;5100.000;6600.000;8100.000;9600.000;11100.000;12600.000 -> 2500.000;4000.000;5500.000;7000.000;8500.000;10000.000;11500.000;13050.000 (DATA_EN is 0 V across all of it)
// leakage sub-window  : 2400.000-2500.000;3900.000-4000.000;5400.000-5500.000;6900.000-7000.000;8400.000-8500.000;9900.000-10000.000;11400.000-11500.000;12950.000-13050.000 (criterion: max(abs(I_sink)) <= 1.5e-07 A, the deck spells it 150n)
// code change rule    : each code changes with a 2 ns edge in the middle of the 500 ns pure-off window before its own rising edge, so no change coincides with an enable edge and none interpolates across a window
// settled before edge : 1000.000;199.000;199.000;199.000;199.000;199.000;199.000;199.000 ns
// stop / maxstep      : 13050.000 ns / 2.000 ns
// analysis            : tran_case tran stop=13050.000n maxstep=2.000n
// launch plan         : 1 DUT process + 1 preflight process
// windows declared for this case: TR-LONG#F0, TR-LONG#F1, TR-LONG#F2, TR-LONG#F3, TR-LONG#F4, TR-LONG#F5, TR-LONG#F6, TR-LONG#F7, TR-LONG#L0, TR-LONG#L1, TR-LONG#L2, TR-LONG#L3, TR-LONG#L4, TR-LONG#L5, TR-LONG#L6, TR-LONG#L7, TR-LONG#O0, TR-LONG#O1, TR-LONG#O2, TR-LONG#O3, TR-LONG#O4, TR-LONG#O5, TR-LONG#O6, TR-LONG#O7, TR-LONG#T0, TR-LONG#T1, TR-LONG#T2, TR-LONG#T3, TR-LONG#T4, TR-LONG#T5, TR-LONG#T6, TR-LONG#T7, TR-LONG#W0, TR-LONG#W1, TR-LONG#W2, TR-LONG#W3, TR-LONG#W4, TR-LONG#W5, TR-LONG#W6, TR-LONG#W7
//
// ---- probe and sign, fixed before any run -------------------------------------------------
// Ip_branch (clamp_node data_out) iprobe, so a positive reading IS the selected branches
// sinking current out of data_out: I_sink = Ip_branch, with no negation and no abs(). The
// physical positive path is clamp_node -> data_out -> the conducting branch(es) -> vss, which
// is the same terminal order the accepted DATA-7B bench uses. A shutoff tail keeps its own
// sign: Q, Qpos and the magnitude of Qneg are reported separately and never cancel.
simulator lang=spectre insensitive=yes

// PDK path and model section come from the environment; no model card is copied into this
// repository and none was read this round.
include "${QODER_PDK_LIB}" section=tt
// the temperature is a deck condition, not a contract adjective
simopt options temp=27

include "${QODER_NETLIST_DIR}/dd1_d6_inv18.scs"
include "${QODER_NETLIST_DIR}/dd1_d6_bias_core.scs"
include "${QODER_NETLIST_DIR}/dd1_d7c_a_gates.scs"
include "${QODER_NETLIST_DIR}/dd1_d7c_a_pam_dec.scs"
include "${QODER_NETLIST_DIR}/dd1_d7c_a_sink_unit.scs"
include "${QODER_NETLIST_DIR}/dd1_d7c_a_pam_top.scs"

// ---- the device under test: one output, eight selectable branches (delivered, unmodified)
Xdut (data_en pam0 pam1 pam2 iref_in vcas data_out vdd18 vss) dd1_d7c_a_pam_1ch

// ---- testbench side: reference and supplies, every node referenced to a real 0 V
Iref_in (irefbus iref_in) isource dc=15u
Viref (irefbus 0) vsource dc=0
Vdd18 (vdd18 0) vsource dc=1.8
Vss (vss 0) vsource dc=0
Vcas (vcas 0) vsource dc=1.8
Vclamp (clamp_node 0) vsource dc=1.2
// Finite-slope enable as absolute times, low at t=0 and with no extra point inside a
// ramp, so the interpolated 50% crossing is the edge the schedule declares. Envelope
// 0.000 ns .. 13050.000 ns (34 points).
Vdata_en (data_en 0) vsource type=pwl wave=[0n 0.000 1000n 0.000 1100n 1.800 2000n 1.800 2100n 0.000 2500n 0.000 2600n 1.800 3500n 1.800 3600n 0.000 4000n 0.000 4100n 1.800 5000n 1.800 5100n 0.000 5500n 0.000 5600n 1.800 6500n 1.800 6600n 0.000 7000n 0.000 7100n 1.800 8000n 1.800 8100n 0.000 8500n 0.000 8600n 1.800 9500n 1.800 9600n 0.000 10000n 0.000 10100n 1.800 11000n 1.800 11100n 0.000 11500n 0.000 11600n 1.800 12500n 1.800 12600n 0.000 13050n 0.000]
// pam0 holds its value and changes only with the 2.000 ns edge inside a pure-off window: 0.000 ns .. 11301.000 ns (15 points)
VPAM0 (pam0 0) vsource type=pwl wave=[0n 0.000 2299n 0.000 2301n 1.800 3799n 1.800 3801n 0.000 5299n 0.000 5301n 1.800 6799n 1.800 6801n 0.000 8299n 0.000 8301n 1.800 9799n 1.800 9801n 0.000 11299n 0.000 11301n 1.800]
// pam1 holds its value and changes only with the 2.000 ns edge inside a pure-off window: 0.000 ns .. 11301.000 ns (15 points)
VPAM1 (pam1 0) vsource type=pwl wave=[0n 0.000 2299n 0.000 2301n 0.000 3799n 0.000 3801n 1.800 5299n 1.800 5301n 1.800 6799n 1.800 6801n 0.000 8299n 0.000 8301n 0.000 9799n 0.000 9801n 1.800 11299n 1.800 11301n 1.800]
// pam2 holds its value and changes only with the 2.000 ns edge inside a pure-off window: 0.000 ns .. 11301.000 ns (15 points)
VPAM2 (pam2 0) vsource type=pwl wave=[0n 0.000 2299n 0.000 2301n 0.000 3799n 0.000 3801n 0.000 5299n 0.000 5301n 0.000 6799n 0.000 6801n 1.800 8299n 1.800 8301n 1.800 9799n 1.800 9801n 1.800 11299n 1.800 11301n 1.800]
// A second analysis form is deliberately absent: this deck declares one tran line, so a
// reviewer can tell which stop and maxstep the case was planned with.

// ---- observation points. Hierarchical saves are NOT_VERIFIED on this build; if the native
// stage refuses them the fallback is to lift the node in a draft copy of the unit subckt,
// never to edit the delivered candidate.
Ip_branch (clamp_node data_out) iprobe
save vdd18 vss iref_in vcas data_out clamp_node irefbus data_en pam0 pam1 pam2
save Xdut.en0 Xdut.en1 Xdut.en2 Xdut.en3 Xdut.en4 Xdut.en5 Xdut.en6 Xdut.en7
save Xdut.enb0 Xdut.enb1 Xdut.enb2 Xdut.enb3 Xdut.enb4 Xdut.enb5 Xdut.enb6 Xdut.enb7
save Xdut.Xu0.vbias_ch Xdut.Xu1.vbias_ch Xdut.Xu2.vbias_ch Xdut.Xu3.vbias_ch
save Xdut.Xu4.vbias_ch Xdut.Xu5.vbias_ch Xdut.Xu6.vbias_ch Xdut.Xu7.vbias_ch
save Xdut.Xu0.node_m Xdut.Xu4.node_m
save Ip_branch Ip_branch:current

tran_case tran stop=13050.000n maxstep=2.000n

// result column for this case in tests/dd1_d7c_b_prep/schedule.csv: NOT_RUN
