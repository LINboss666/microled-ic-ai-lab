// RS-FULL.scs -- DATA-7C-B-PREP deck for case RS-FULL. TEXT ONLY, NEVER RUN.
//
// Generated by scripts/dd1_d7c_b_prep_deckgen.py from tests/dd1_d7c_b_prep/contract.json and
// tests/dd1_d7c_b_prep/schedule.csv. Do not edit this file by hand: change the source and
// regenerate, otherwise the schedule and the deck disagree, which is the defect this round
// exists to remove. Contract state: PROPOSED_FOR_REVIEW (not USER_APPROVED).
// Authorisation: NEW_SPECTRE_LAUNCH_LIMIT=0, NATIVE_PREFLIGHT_AUTHORISED=NO,
// NEXT_NATIVE_STAGE_AUTHORISED=NO. Nothing in this file has been run, and running it is not
// authorised by this round. NATIVE_NETLIST_SYNTAX=NOT_VERIFIED, so the pwl spelling below and
// the hierarchical saves are text a reviewer reads, not a proven feature of this build.
//
// ---- this case, in numbers -------------------------------------------------------
// class                : refined_step
// pam_sel               : 000..111  (bit0=pam0 weight 1, bit1=pam1 weight 2, bit2=pam2 weight 4)
// DATA_EN form          : pwl_per_platform at 1.800 V
// supplies              : vdd18=1.8 V, vcas=1.8 V, vss=explicit 0 V source, Iref=1.5e-05 A (the deck writes it as 15u)
// output clamp          : 1.2 V (POC condition, not VLED, not VSCAN, not SOA)
// initial off lead    : 1000.000 ns, offset applied to every instant of this case: 1000.000 ns
// platform start/stop : 1000.000;2500.000;4000.000;5500.000;7000.000;8500.000;10000.000;11500.000 / 2000.000;3500.000;5000.000;6500.000;8000.000;9500.000;11000.000;12500.000
// 50% enable edges    : rise 1000.000;2500.000;4000.000;5500.000;7000.000;8500.000;10000.000;11500.000 / fall 2000.000;3500.000;5000.000;6500.000;8000.000;9500.000;11000.000;12500.000
// integration window  : 1050.000;2550.000;4050.000;5550.000;7050.000;8550.000;10050.000;11550.000 -> 1950.000;3450.000;4950.000;6450.000;7950.000;9450.000;10950.000;12450.000 (the flat part, inset by the ramp time)
// off window          : 2500.000-2450.000;4000.000-3950.000;5500.000-5450.000;7000.000-6950.000;8500.000-8450.000;10000.000-9950.000;11500.000-11450.000
// tail window         : 2000.000;3500.000;5000.000;6500.000;8000.000;9500.000;11000.000;12500.000 -> 2500.000;4000.000;5500.000;7000.000;8500.000;10000.000;11500.000;13000.000
// leakage sub-window  : last 100 ns from 2400.000;3900.000;5400.000;6900.000;8400.000;9900.000;11400.000;12900.000 ns (criterion: max(abs(I_sink)) <= 1.5e-07 A, the deck spells it 150n)
// code change rule    : each code changes 250.000 ns before its own rising edge, the middle of the 500.000 ns off window, so no change coincides with an enable edge
// settled before edge : 250.000;250.000;250.000;250.000;250.000;250.000;250.000;250.000 ns
// stop / maxstep      : 13500.000 ns / 0.100 ns
// analysis            : tran stop=13500.000n maxstep=0.100n
// paired with         : TR-LONG, identical stimulus and windows, only maxstep differs
// launch plan         : 1 DUT process + 1 preflight process
// windows declared for this case: RS-FULL#T0, RS-FULL#T1, RS-FULL#T2, RS-FULL#T3, RS-FULL#T4, RS-FULL#T5, RS-FULL#T6, RS-FULL#T7, RS-FULL#W0, RS-FULL#W1, RS-FULL#W2, RS-FULL#W3, RS-FULL#W4, RS-FULL#W5, RS-FULL#W6, RS-FULL#W7
//
// ---- probe and sign, fixed before any run --------------------------------------------------
// Ip_branch (clamp_node data_out) iprobe, so a positive reading IS the selected branches
// sinking current out of data_out: I_sink = Ip_branch, with no negation and no abs(). The
// physical positive path is clamp_node -> data_out -> the conducting branch(es) -> vss, which
// is the same terminal order the accepted DATA-7B bench uses. A shutoff tail keeps its own
// sign: Q, Qpos and the magnitude of Qneg are reported separately and never cancel.
simulator lang=spectre insensitive=yes

// PDK path and model section come from the environment; no model card is copied into this
// repository and none was read this round.
include "${QODER_PDK_LIB}" section=tt

include "${QODER_NETLIST_DIR}/dd1_d6_inv18.scs"
include "${QODER_NETLIST_DIR}/dd1_d6_bias_core.scs"
include "${QODER_NETLIST_DIR}/dd1_d7c_a_gates.scs"
include "${QODER_NETLIST_DIR}/dd1_d7c_a_pam_dec.scs"
include "${QODER_NETLIST_DIR}/dd1_d7c_a_sink_unit.scs"
include "${QODER_NETLIST_DIR}/dd1_d7c_a_pam_top.scs"

// ---- the device under test: one output, eight selectable branches (delivered, unmodified)
Xdut (data_en pam0 pam1 pam2 iref_in vcas data_out vdd18 vss) dd1_d7c_a_pam_1ch

// ---- testbench side: reference and supplies, every node referenced to a real 0 V
Iref_in (irefbus iref_in) isource dc=15u
Viref (irefbus 0) vsource dc=0
Vdd18 (vdd18 0) vsource dc=1.8
Vss (vss 0) vsource dc=0
Vcas (vcas 0) vsource dc=1.8
Vclamp (clamp_node 0) vsource dc=1.2
// Finite-slope enable written as absolute times, low at t=0 so the first rise is a real
// edge. Envelope 0.000 ns .. 12550.000 ns (34 points). Ramp is symmetric about its 50% point, so the flat part between
// the ramps is exactly the integration window declared above.
Vdata_en (data_en 0) vsource type=pwl time={0.000n 950.000n 1000.000n 1050.000n 1950.000n 2050.000n 2450.000n 2550.000n 3450.000n 3550.000n 3950.000n 4050.000n 4950.000n 5050.000n 5450.000n 5550.000n 6450.000n 6550.000n 6950.000n 7050.000n 7950.000n 8050.000n 8450.000n 8550.000n 9450.000n 9550.000n 9950.000n 10050.000n 10950.000n 11050.000n 11450.000n 11550.000n 12450.000n 12550.000n} value={0.000 0.000 0.000 1.800 1.800 0.000 0.000 1.800 1.800 0.000 0.000 1.800 1.800 0.000 0.000 1.800 1.800 0.000 0.000 1.800 1.800 0.000 0.000 1.800 1.800 0.000 0.000 1.800 1.800 0.000 0.000 1.800 1.800 0.000}
// pam0 changes only inside an off window: 0.000 ns .. 11250.000 ns (9 points)
VPAM0 (pam0 0) vsource type=pwl time={0.000n 750.000n 2250.000n 3750.000n 5250.000n 6750.000n 8250.000n 9750.000n 11250.000n} value={0.000 0.000 0.000 0.000 0.000 1.000 1.000 1.000 1.000}
// pam1 changes only inside an off window: 0.000 ns .. 11250.000 ns (9 points)
VPAM1 (pam1 0) vsource type=pwl time={0.000n 750.000n 2250.000n 3750.000n 5250.000n 6750.000n 8250.000n 9750.000n 11250.000n} value={0.000 0.000 0.000 1.000 1.000 0.000 0.000 1.000 1.000}
// pam2 changes only inside an off window: 0.000 ns .. 11250.000 ns (9 points)
VPAM2 (pam2 0) vsource type=pwl time={0.000n 750.000n 2250.000n 3750.000n 5250.000n 6750.000n 8250.000n 9750.000n 11250.000n} value={0.000 0.000 1.000 0.000 1.000 0.000 1.000 0.000 1.000}
// A second analysis form is deliberately absent: this deck declares one tran line, so a
// reviewer can tell which stop and maxstep the case was planned with.

// ---- observation points. Hierarchical saves are NOT_VERIFIED on this build; if the native
// stage refuses them the fallback is to lift the node in a draft copy of the unit subckt, never
// to edit the delivered candidate.
Ip_branch (clamp_node data_out) iprobe
save vdd18 vss iref_in vcas data_out clamp_node irefbus data_en pam0 pam1 pam2
save Xdut.en0 Xdut.en1 Xdut.en2 Xdut.en3 Xdut.en4 Xdut.en5 Xdut.en6 Xdut.en7
save Xdut.enb0 Xdut.enb1 Xdut.enb2 Xdut.enb3 Xdut.enb4 Xdut.enb5 Xdut.enb6 Xdut.enb7
save Xdut.Xu0.vbias_ch Xdut.Xu1.vbias_ch Xdut.Xu2.vbias_ch Xdut.Xu3.vbias_ch
save Xdut.Xu4.vbias_ch Xdut.Xu5.vbias_ch Xdut.Xu6.vbias_ch Xdut.Xu7.vbias_ch
save Ip_branch Ip_branch:current

tran stop=13500.000n maxstep=0.100n

// result column for this case in tests/dd1_d7c_b_prep/schedule.csv: NOT_RUN
