// PDK model probe -- SMIC 0.18um EEPROM 1.8/3.3/5/15.5V 2P6M (e2r018 v1.8, BSIM3v3)
// The card's own `tt` section includes e2r018_v1p8_spe.mdl, so one include is enough.
// Core NMOS n18e2r at the 1.8 V nominal rail, 100k pull-up:
//   Vgs = 0   -> off -> V(d) = 1.8 V
//   Vgs = 1.8 -> on  -> V(d) well below 1.8 V
simulator lang=spectre insensitive=yes

include "${QODER_SMIC18EE_LIB}" section=tt

Vdd (vdd 0) vsource  dc=1.8
Rup (vdd d) resistor r=100e3
Vgs (g 0)   vsource  dc=0

M1 (d g 0 0) n18e2r l=180e-9 w=2e-6

sw1 dc dev=Vgs param=dc start=0 stop=1.8 step=0.2

save d g
