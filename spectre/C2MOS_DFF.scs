// ==============================================================================
// C2MOS_DFF.scs -- one fully-static C^2MOS master-slave D flip-flop
// Process : teacher copy smic18mmrf_teacher, section=tt, 1.8 V core devices n18/p18
// Spectre BSIM4 terminal order used everywhere:  Name ( d g s b ) ModelName
//
// Internal clock polarity (stated explicitly, as requested):
//   The cell has ONE external clock pin `clk`. `clkb` is generated by the internal
//   inverter mn_c/mp_c, so clkb = !clk and no external non-overlap is required.
//   clk  = 0 -> MASTER evaluates (m = !d), SLAVE holds
//   clk  = 1 -> MASTER holds, SLAVE evaluates (q = !m = d)
//   => POSITIVE-EDGE-TRIGGERED, D -> Q non-inverting (two inversions).
//
// Why each stack cannot fight the keeper (this is the C^2MOS trick):
//   In every clocked stack ONE device is clock-driven and the other data-driven, and
//   the two clock devices of a stage are driven by OPPOSITE phases
//   (master: PMOS side from clk, NMOS side from clkb; slave: mirrored).
//   During the inactive half-cycle BOTH clock devices are OFF, so each stack is broken
//   at the rail side for ANY value of the data input -- no dc path to VDD or VSS, hence
//   nothing can contend with the keeper. Changing D while the phase is inactive is
//   therefore harmless.
//
// This is NOT a claim that the earlier transfer-gate cell was topologically wrong.
// Both cells were run against a testbench whose `vss` net was never tied to ground,
// which alone is enough to explain the old symptoms; see the note above the subckt.
//
// Keeper sizing: cross-coupled weak inverter pairs (m<->mb, q<->qbar), W = 0.25 x the
//   clocked-path width. What has actually been measured is that at tt, 1.8 V, 27 C and
//   a 50 fF load a write wins and the node is actively restored (fully static) during
//   the inactive half-cycle. That is NOT a guarantee over voltage, temperature, process
//   spread or mismatch -- none of those have been run here, so no always/guaranteed/
//   all-corners statement belongs in this file.
//
// This cell has NO reset, NO pulse generator and NO scan power output stage; the scan
// output domain (VLED / Micro LED Vf) stays NOT DEFINED and is frozen this round.
// ==============================================================================
simulator lang=spectre insensitive=yes

subckt c2mos_dff (d clk q qbar vdd vss)
  // Sizes live inside the subckt so an instance can override them
  // (X1 (...) c2mos_dff wc=4e-6). NOTE: this was NOT the reason the first run of
  // this cell was dead -- top-level parameters resolve fine here too. The real cause
  // was that the testbench never connected the `vss` net to ground: a net used only
  // for sources and bulks has no current path, so every NMOS conducted 0 A and the
  // whole cell floated at ~VDD. Proved by spectre/nmos_probe.scs: the same n18 at top
  // level, inside a subckt with `parameters`, and inside a subckt with literals all
  // behaved identically once Vss (vss 0) vsource dc=0 was added, and all three were
  // dead without it.
  parameters ln=2e-7
  parameters wc=2e-6      // clocked-path NMOS width
  parameters wcp=4e-6     // clocked-path PMOS width
  parameters wk=5e-7      // keeper NMOS width  = 0.25 x wc
  parameters wkp=1e-6     // keeper PMOS width  = 0.25 x wcp

  // ---- internal clock inversion: clkb = !clk
  mn_c (clkb clk vss vss) n18 l=ln w=wc
  mp_c (clkb clk vdd vdd) p18 l=ln w=wcp

  // ---- MASTER clocked inverter, evaluates while clk=0, holds while clk=1
  // pull-up : conducts when clk=0 AND d=0   => m = 1
  mp_m1 (x1 clk  vdd vdd) p18 l=ln w=wcp     // clock device sits at the rail
  mp_m2 (m  d    x1  vdd) p18 l=ln w=wcp     // data device sits at the node
  // pull-down: conducts when clkb=1 AND d=1 => m = 0
  mn_m1 (x2 clkb vss vss) n18 l=ln w=wc
  mn_m2 (m  d    x2  vss) n18 l=ln w=wc
  // weak keeper, makes the master storage node fully static
  mn_k1 (mb m    vss vss) n18 l=ln w=wk
  mp_k1 (mb m    vdd vdd) p18 l=ln w=wkp
  mn_k2 (m  mb   vss vss) n18 l=ln w=wk
  mp_k2 (m  mb   vdd vdd) p18 l=ln w=wkp

  // ---- SLAVE clocked inverter, evaluates while clk=1, holds while clk=0
  // data input is m, so d -> m -> q is non-inverting
  // pull-up : conducts when clkb=0 AND m=0   => q = 1
  mp_s1 (y1 clkb vdd vdd) p18 l=ln w=wcp
  mp_s2 (q  m    y1  vdd) p18 l=ln w=wcp
  // pull-down: conducts when clk=1 AND m=1   => q = 0
  mn_s1 (y2 clk  vss vss) n18 l=ln w=wc
  mn_s2 (q  m    y2  vss) n18 l=ln w=wc
  // weak keeper on the slave node; qbar is the stored complement
  mn_k3 (qbar q   vss vss) n18 l=ln w=wk
  mp_k3 (qbar q   vdd vdd) p18 l=ln w=wkp
  mn_k4 (q    qbar vss vss) n18 l=ln w=wk
  mp_k4 (q    qbar vdd vdd) p18 l=ln w=wkp

ends c2mos_dff
