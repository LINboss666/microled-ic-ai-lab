// PDK model probe -- SMIC 018 MM RF, TEACHER COPY, 3.3 V IO pair (n33 / p33, BSIM4)
// Same single-sweep trick as the 1.8 V probe; rail is 3.3 V.
// Geometry obeys the card limits: n33 lmin=3.5e-7, p33 lmin=3e-7, wmin=2.2e-7, wmax=1e-4.
simulator lang=spectre insensitive=yes

include "${QODER_PDK_LIB}" section=tt

Vdd  (vdd 0)  vsource  dc=3.3
Vgs  (g 0)    vsource  dc=0
Run  (vdd dn)  resistor r=100e3
Rpd  (dp 0)    resistor r=100e3

Mn (dn g 0 0)     n33 l=400e-9 w=5e-6
Mp (dp g vdd vdd) p33 l=400e-9 w=5e-6

sw1 dc dev=Vgs param=dc start=0 stop=3.3 step=0.3

save dn dp g vdd
