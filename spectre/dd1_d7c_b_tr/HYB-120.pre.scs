// HYB-120.scs -- DATA-7C-B-TR run copy generated from the accepted RTL four-state VCD. THIS CASE RUNS, accounted against the approved limit.
// TR-IDENTITY: task=DATA-7C-B-TR
// TR-IDENTITY: base_sha=61621f6e3d887082ecd6a7ecc1c771f8e509a24a
// TR-IDENTITY: branch=poc/data-pam-d7c-b-tr
// TR-IDENTITY: case=HYB-120
// TR-IDENTITY: role=preflight
// TR-IDENTITY: preflight_derivation=the same supplies, the same PWL inputs, the same span and the same maxstep; the DUT is replaced by the ideal meter loads and its hierarchy saves are dropped because no DUT exists here
// TR-IDENTITY: preflight_may_not_be_read_as=a shut-off or ladder result, an ideal resistive preflight does not switch off with DATA_EN
// TR-IDENTITY: contract=tests/dd1_d7c_b_tr/contract.json
// TR-IDENTITY: contract_sha256=87b830f100450bc3370cf49661f85db023e0579cb097d358af36b66c9658f3bb
// TR-IDENTITY: authorisation=USER_APPROVED_SPECTRE_LIMIT_24_RTL_LIMIT_4
// TR-IDENTITY: approval=2026-10-26_YES
// TR-IDENTITY: analysis_declared=tran_case tran stop=44686.000n maxstep=0.100n
// TR-IDENTITY: derivation=generated from the accepted RTL four-state VCD; every statement line other than those is byte-identical to the template body
// TR-IDENTITY: frame_count=5
// TR-IDENTITY: inherited_comment_blocks=they describe the template case TR-LONG; the delivered statements and this identity block are the condition of this run copy
// TR-IDENTITY: maxstep_ns=0.1
// TR-IDENTITY: rtl_blob_sha256=6dbf464a49e49ad489188fa51920c30a3c89d6b3106046a4fefe558ef0a50c87
// TR-IDENTITY: stop_ns=44686
// TR-IDENTITY: substituted_lines=the four logic pwl waves, the tran line and the first comment
// TR-IDENTITY: template_deck=spectre/dd1_d7c_b_prep/TR-LONG.scs
// TR-IDENTITY: template_deck_sha256=54506e945920713fba2682d0d535aa04c1cd9b1718b12395bf83c4841c8f78d5
// TR-IDENTITY: template_first_line_replaced=YES
// TR-IDENTITY: tick_ns=120
// TR-IDENTITY: tick_ps=120000
// TR-IDENTITY: vcd_sha256=0d07a25a55787e3c6eda262e9c03d9b01c30fb21790ef90d49d3af5d604a191f
// TR-IDENTITY: wave_data_en_initial_V=0.000
// TR-IDENTITY: wave_data_en_points=18
// TR-IDENTITY: wave_data_en_span_ns=0.000..44686.000
// TR-IDENTITY: wave_pam0_initial_V=0.000
// TR-IDENTITY: wave_pam0_points=12
// TR-IDENTITY: wave_pam0_span_ns=0.000..44686.000
// TR-IDENTITY: wave_pam1_initial_V=0.000
// TR-IDENTITY: wave_pam1_points=12
// TR-IDENTITY: wave_pam1_span_ns=0.000..44686.000
// TR-IDENTITY: wave_pam2_initial_V=0.000
// TR-IDENTITY: wave_pam2_points=8
// TR-IDENTITY: wave_pam2_span_ns=0.000..44686.000
// TR-IDENTITY: master=dd1_d6_inv18.scs=d535ad0112c31952d0c51e314cc57054b631b18c7457ba8088d970945ca6de77
// TR-IDENTITY: master=dd1_d6_bias_core.scs=379536efb1dd9b2626e93ec384d572c734d5c1b398881c6de6ce4405e230c293
// TR-IDENTITY: master=dd1_d7c_a_gates.scs=55c08f25eaee6184c8be263e8762559f51ff1c66be37c0a0dfb1c2b0e8f1e5de
// TR-IDENTITY: master=dd1_d7c_a_pam_dec.scs=f4d458d21d82e91c3f0e4012cc8fb568c090c1bb364fd486bf0b82a469163b5a
// TR-IDENTITY: master=dd1_d7c_a_sink_unit.scs=289ae1dd8edf91c806c2c2dfecc15d9b3b8524ed987849d0094bab1124369a3f
// TR-IDENTITY: master=dd1_d7c_a_pam_top.scs=8489616e4826fccdd7516d7b02764ae3850ad3e4476181b5ae0f5249ec5a08a5
// TR-IDENTITY: geometry_body_and_reference_unchanged=YES
// TR-IDENTITY: pdk_library_and_schematic_untouched=YES
// TR-IDENTITY: this_copy_runs=YES: the approved DATA-7C-B-TR accounts this case against the limit of 24 processes, so an inherited TEXT ONLY banner in the frozen first line describes the preparation round only
//
// Generated by scripts/dd1_d7c_b_prep_deckgen.py from tests/dd1_d7c_b_prep/contract.json and
// tests/dd1_d7c_b_prep/schedule.csv. Do not edit this file by hand: change the source and
// regenerate, otherwise the schedule and the deck disagree, which is the defect this round
// exists to remove. Contract state: PROPOSED_FOR_REVIEW (not USER_APPROVED).
// Authorisation: NEW_SPECTRE_LAUNCH_LIMIT=0, NATIVE_PREFLIGHT_AUTHORISED=NO,
// NEXT_NATIVE_STAGE_AUTHORISED=NO. Nothing in this file has been run, and running it is not
// authorised by this round. NATIVE_NETLIST_SYNTAX=NOT_VERIFIED: the analysis and pwl forms
// below are the ones this project has already run (scripts/dd1_d7b_run.py:239 and :288,
// spectre/current_probe_syntax.scs:35), but hierarchical saves are still unproven on them.
//
// ---- this case, in numbers -------------------------------------------------------
// class                 : transient
// pam_sel               : 000..111  (pam0=bit0 weight 1, pam1=bit1 weight 2, pam2=bit2 weight 4)
// DATA_EN form          : pwl_per_platform at 1.800 V (the 1.800 V logic domain, never the bit itself)
// temperature           : simopt options temp=27, written as a statement in this deck
// supplies              : vdd18=1.8 V, vcas=1.8 V, vss=explicit 0 V source, Iref=1.5e-05 A (the deck writes it as 15u)
// output clamp          : 1.2 V (POC condition, not VLED, not VSCAN, not SOA)
// pure-off preparation: ends at 1000.000 ns; offset applied to every instant of this case: 1050.000 ns; half-edge 50.000 ns
// platform (rise50/fall50): 1050.000;2550.000;4050.000;5550.000;7050.000;8550.000;10050.000;11550.000 / 2050.000;3550.000;5050.000;6550.000;8050.000;9550.000;11050.000;12550.000
// ramp endpoints      : rise 1000.000;2500.000;4000.000;5500.000;7000.000;8500.000;10000.000;11500.000->1100.000;2600.000;4100.000;5600.000;7100.000;8600.000;10100.000;11600.000, fall 2000.000;3500.000;5000.000;6500.000;8000.000;9500.000;11000.000;12500.000->2100.000;3600.000;5100.000;6600.000;8100.000;9600.000;11100.000;12600.000
// full-enable window  : 1050.000;2550.000;4050.000;5550.000;7050.000;8550.000;10050.000;11550.000 -> 2050.000;3550.000;5050.000;6550.000;8050.000;9550.000;11050.000;12550.000 (rise50 to fall50; the charge convergence compares)
// flat part           : 1100.000;2600.000;4100.000;5600.000;7100.000;8600.000;10100.000;11600.000 -> 2000.000;3500.000;5000.000;6500.000;8000.000;9500.000;11000.000;12500.000 (the mean current and the sign rule)
// tail charge window  : 2050.000;3550.000;5050.000;6550.000;8050.000;9550.000;11050.000;12550.000 -> 2500.000;4000.000;5500.000;7000.000;8500.000;10000.000;11500.000;13050.000
// pure-off window     : 2100.000;3600.000;5100.000;6600.000;8100.000;9600.000;11100.000;12600.000 -> 2500.000;4000.000;5500.000;7000.000;8500.000;10000.000;11500.000;13050.000 (DATA_EN is 0 V across all of it)
// leakage sub-window  : 2400.000-2500.000;3900.000-4000.000;5400.000-5500.000;6900.000-7000.000;8400.000-8500.000;9900.000-10000.000;11400.000-11500.000;12950.000-13050.000 (criterion: max(abs(I_sink)) <= 1.5e-07 A, the deck spells it 150n)
// code change rule    : each code changes with a 2 ns edge in the middle of the 500 ns pure-off window before its own rising edge, so no change coincides with an enable edge and none interpolates across a window
// settled before edge : 1000.000;199.000;199.000;199.000;199.000;199.000;199.000;199.000 ns
// stop / maxstep      : 13050.000 ns / 2.000 ns
// analysis            : tran_case tran stop=13050.000n maxstep=2.000n
// launch plan         : 1 DUT process + 1 preflight process
// windows declared for this case: TR-LONG#F0, TR-LONG#F1, TR-LONG#F2, TR-LONG#F3, TR-LONG#F4, TR-LONG#F5, TR-LONG#F6, TR-LONG#F7, TR-LONG#L0, TR-LONG#L1, TR-LONG#L2, TR-LONG#L3, TR-LONG#L4, TR-LONG#L5, TR-LONG#L6, TR-LONG#L7, TR-LONG#O0, TR-LONG#O1, TR-LONG#O2, TR-LONG#O3, TR-LONG#O4, TR-LONG#O5, TR-LONG#O6, TR-LONG#O7, TR-LONG#T0, TR-LONG#T1, TR-LONG#T2, TR-LONG#T3, TR-LONG#T4, TR-LONG#T5, TR-LONG#T6, TR-LONG#T7, TR-LONG#W0, TR-LONG#W1, TR-LONG#W2, TR-LONG#W3, TR-LONG#W4, TR-LONG#W5, TR-LONG#W6, TR-LONG#W7
//
// ---- probe and sign, fixed before any run -------------------------------------------------
// Ip_branch (clamp_node data_out) iprobe, so a positive reading IS the selected branches
// sinking current out of data_out: I_sink = Ip_branch, with no negation and no abs(). The
// physical positive path is clamp_node -> data_out -> the conducting branch(es) -> vss, which
// is the same terminal order the accepted DATA-7B bench uses. A shutoff tail keeps its own
// sign: Q, Qpos and the magnitude of Qneg are reported separately and never cancel.
simulator lang=spectre insensitive=yes

// PDK path and model section come from the environment; no model card is copied into this
// repository and none was read this round.
include "${QODER_PDK_LIB}" section=tt
// the temperature is a deck condition, not a contract adjective
simopt options temp=27

include "${QODER_NETLIST_DIR}/dd1_d6_inv18.scs"
include "${QODER_NETLIST_DIR}/dd1_d6_bias_core.scs"
include "${QODER_NETLIST_DIR}/dd1_d7c_a_gates.scs"
include "${QODER_NETLIST_DIR}/dd1_d7c_a_pam_dec.scs"
include "${QODER_NETLIST_DIR}/dd1_d7c_a_sink_unit.scs"
include "${QODER_NETLIST_DIR}/dd1_d7c_a_pam_top.scs"

// ---- the device under test: one output, eight selectable branches (delivered, unmodified)
Rload_meter (data_out vss) resistor r=80e3
Rref_meter (iref_in vss) resistor r=50e3

// ---- testbench side: reference and supplies, every node referenced to a real 0 V
Iref_in (irefbus iref_in) isource dc=15u
Viref (irefbus 0) vsource dc=0
Vdd18 (vdd18 0) vsource dc=1.8
Vss (vss 0) vsource dc=0
Vcas (vcas 0) vsource dc=1.8
Vclamp (clamp_node 0) vsource dc=1.2
// Finite-slope enable as absolute times, low at t=0 and with no extra point inside a
// ramp, so the interpolated 50% crossing is the edge the schedule declares. Envelope
// 0.000 ns .. 13050.000 ns (34 points).
Vdata_en (data_en 0) vsource type=pwl wave=[0n 0.000 12515n 0.000 12517n 1.800 12635n 1.800 12637n 0.000 22665n 0.000 22667n 1.800 22905n 1.800 22907n 0.000 32815n 0.000 32817n 1.800 40495n 1.800 40497n 0.000 42965n 0.000 42967n 1.800 43268n 1.800 43270n 0.000 44686n 0.000]
// pam0 holds its value and changes only with the 2.000 ns edge inside a pure-off window: 0.000 ns .. 11301.000 ns (15 points)
VPAM0 (pam0 0) vsource type=pwl wave=[0n 0.000 22545n 0.000 22547n 1.800 31477n 1.800 31479n 0.000 32695n 0.000 32697n 1.800 41627n 1.800 41629n 0.000 42845n 0.000 42847n 1.800 44686n 1.800]
// pam1 holds its value and changes only with the 2.000 ns edge inside a pure-off window: 0.000 ns .. 11301.000 ns (15 points)
VPAM1 (pam1 0) vsource type=pwl wave=[0n 0.000 22545n 0.000 22547n 1.800 31477n 1.800 31479n 0.000 32695n 0.000 32697n 1.800 41627n 1.800 41629n 0.000 42845n 0.000 42847n 1.800 44686n 1.800]
// pam2 holds its value and changes only with the 2.000 ns edge inside a pure-off window: 0.000 ns .. 11301.000 ns (15 points)
VPAM2 (pam2 0) vsource type=pwl wave=[0n 0.000 32695n 0.000 32697n 1.800 41627n 1.800 41629n 0.000 42845n 0.000 42847n 1.800 44686n 1.800]
// A second analysis form is deliberately absent: this deck declares one tran line, so a
// reviewer can tell which stop and maxstep the case was planned with.

// ---- observation points. Hierarchical saves are NOT_VERIFIED on this build; if the native
// stage refuses them the fallback is to lift the node in a draft copy of the unit subckt,
// never to edit the delivered candidate.
Ip_branch (clamp_node data_out) iprobe
save vdd18 vss iref_in vcas data_out clamp_node irefbus data_en pam0 pam1 pam2
save Ip_branch Ip_branch:current

tran_case tran stop=44686.000n maxstep=0.100n

// result column for this case in tests/dd1_d7c_b_prep/schedule.csv: NOT_RUN
