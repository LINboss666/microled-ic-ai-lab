// Minimal transfer-gate unit test -- TG supposed ON.
// Deliberately uses NO subckt and NO `parameters`: only literals, so it isolates the
// one unverified assumption left after the shift-cell failures -- whether a SMIC
// `n18`/`p18` device written as (drain gate bulk source) behaves as I assume.
// Authoritative terminal order, from `spectre -h bsim4` on this host:
//   Name ( d g s b ) ModelName     <- bulk is the LAST terminal
// Pass device: NM gate=1.8, PM gate=0 -> both conduct -> out must follow d.
simulator lang=spectre insensitive=yes

include "${QODER_PDK_LIB}" section=tt

Vdd (vdd 0) vsource dc=1.8
Vd  (d    0) vsource dc=0
Vgn (gn   0) vsource dc=1.8
Vgp (gp   0) vsource dc=0

MN (out gn d vss) n18 l=2e-7 w=2e-6
MP (out gp d vdd) p18 l=2e-7 w=4e-6
Rd (out 0)  resistor r=1e6

sw1 dc dev=Vd param=dc start=0 stop=1.8 step=0.9

save d out gn gp vdd
